|   Microchip Technology Inc.
|   SAMA7G54DxG Series SiP with DDR3L 1GB / 2GB / 4GB
|   Up to 1-GHz Arm Cortex-A7, MIPI
|   Camera, Dual Ethernet, Audio and Security
| Part Number   Package
|SAMA7G54D1G(T)-I/4UB   TFBGA427, 427-ball TFBGA 18x21x1.2 mm, 0.8 mm pitch,
|SAMA7G54D2G(T)-I/4UB   Industrial
|SAMA7G54D4G(T)-I/4UB
|SAMA7G54D1G(T)-I/XHB   TFBGA442, 442-ball TFBGA 16x16x1.2 mm, 0.5 mm pitch
|SAMA7G54D2G(T)-I/XHB   Industrial
|SAMA7G54D4G(T)-I/XHB
|SAMA7G54D1G(T)-E/XHB   TFBGA442, 442-ball TFBGA 16x16x1.2 mm, 0.5 mm pitch
|SAMA7G54D2G(T)-E/XHB   Extended Industrial and Automotive
|SAMA7G54D4G(T)-E/XHB
|SAMA7G54D1G(T)-E/XHB
|SAMA7G54D2G(T)-E/XHB
|SAMA7G54D4G(T)-E/XHB
[IBIS ver]   5.0
[File name]   sama7g54dxg_4ub_xhb.ibs
[File Rev]   2.0
[Date]   May 2024
[Source]   From silicon level SPICE model simulation at Microchip.
[Notes]   This IBIS model is for the Microchip SAMA7D65DxG device.
   1.8V and 3.3V Voltage range for HSIO and GPIO.
   Revision History:
   Rev 1.0: 22/02/2024  Author: PFi
   - HSPICE/IBIS Correlation comparison with HyperLynx
   IBIS simulation.
   - IBIS Quality Level (IQ) analysis based on Specification 2.0
   - Visual inspection where needed.
   - IQ SUMMARY Overall Quality for component and models
   - IBISCHK6 V7.1.0
   IQ Quality Level for Component:
   -  IQ2.
   IQ Quality Level for Model HSIO_* / GPIO_* IOs:
   - IQ2(S).
   - SPICE to IBIS correlation for Clamp, IV and VT tables
   FOM > 98%
   Rev 2.0: 16/05/2024  Author: PFi
   - 4GBit Memory version added in Component Section: SAMA7D54D4G
   - Changed pin description (no impact on electrical model) in all
   Component:
   V20   MIPI_AGND   NC  into  V20   GNDDPHY   GND
   Rev 2.1: 01/06/2026  Author: PFi
   - Added Components and Package RLC for TFBGA442 Ball TFBGA New
   package reference (SAMA7D54D1G_2G_4G_XHB)
   - Corrected signal name into all _4UB Components
   -- Changed: K18   VDDIOPU   POWER into
   K18   VDDCPU   POWER
   -- Changed: J15   VDDANAOUT   POWER into
   J15   VDDANA   POWER
   -- Changed: D9   VREFP   POWER into
   J15   ADVREFP   POWER
   -- Changed: VDDPHY into VDDDPHY
   GNDDPHY into GNDDPHY
[Disclaimer] (C) Copyright Microchip Corporation 2026
                                      All rights reserved
                 Microchip Corporation hereby grants the user of this IBIS
                 model a non-exclusive, nontransferable license to use this
                 IBIS model under the following terms. Before using this IBIS
                 model, the user should read this license. If the user does
                 not accept these terms, the IBIS model should be returned
                 to Microchip within 30 days.
                 The user is granted this license only to use the IBIS model
                 and is not granted rights to sell, load, rent, lease or
                 license the IBIS model in whole or in part, or in modified
                 form to anyone other than user. User may modify the IBIS
                 model to suit its specific applications but rights to
                 derivative works and such modifications shall belong to
                 Microchip.
                 This IBIS model is provided on an "AS IS" basis and Microchip
                 makes absolutely no warranty with respect to the information
                 contained herein.
                 MICROCHIP DISCLAIMS AND CUSTOMER WAIVES ALL WARRANTIES,
                 EXPRESS OR IMPLIED, INCLUDING WARRANTIES OF MERCHANTABILITY
                 OR FITNESS FOR A PARTICULAR PURPOSE.
                 The entire risk as to quality and performance is with the
                 Customer.
                 ACCORDINGLY, IN NO EVENT SHALL THE COMPANY BE LIABLE FOR
                 ANY DAMAGES, WHETHER IN CONTRACT OR TORT,INCLUDING ANY LOST
                 PROFITS OR OTHER INCIDENTAL,CONSEQUENTIAL, EXEMPLARY, OR
                 PUNITIVE DAMAGES ARISING OUT OF THE USE OR APPLICATION OF
                 THE IBIS MODEL PROVIDED IN THIS PACKAGE.
                 Further, Microchip reserves the right to make changes without
                 notice to any product herein to improve reliability,
                 function, or design. Microchip does not convey any license
                 under patent rights or any other intellectual property
                 rights, including those of third parties.
                 Microchip is not obligated to provide maintenance or support
                 for the licensed IBIS model.
[Copyright]   Microchip Technology, Inc.
|   Component SAMA7D54D1G_4UB
[Component]   SAMA7D54D1G_4UB
[Manufacturer]  Microchip Technology Inc.
[Package]
| variable   typ   min   max
R_pkg   536.25m   69.66m   1005.15m
L_pkg   7.56175nH   0.902nH   14.18296nH
C_pkg   0.64654pF   0.0999pF   1.19661pF
[Pin]   signal_name   model_name   R_pin   L_pin   C_pin
J11   AUDIOCLK   GPIO   208.07m   2.69325nH   0.16212pF
N23   PA0   HSIO   184.55m   2.89429nH   0.20344pF
P25   PA1   HSIO   362.2m   4.62716nH   0.22645pF
M19   PA10   HSIO   212.52m   2.55936nH   0.20259pF
N25   PA11   HSIO   354.7m   4.79933nH   0.22187pF
P16   PA12   GPIO   70.93m   0.96438nH   0.10782pF
AA10   PA13   GPIO   711.09m   9.24308nH   0.74380pF
AA11   PA14   GPIO   670.78m   8.73347nH   0.70937pF
V15   PA15   GPIO   270.86m   3.80488nH   0.38136pF
Y15   PA16   GPIO   446.61m   5.73490nH   0.44388pF
W13   PA17   GPIO   421.04m   5.57966nH   0.54874pF
Y13   PA18   GPIO   577.44m   7.38747nH   0.55301pF
U17   PA19   GPIO   213.4m   2.58217nH   0.30922pF
R22   PA2   GPIO   211.15m   2.93259nH   0.27874pF
AA12   PA20   GPIO   681.46m   8.63200nH   0.72315pF
U15   PA21   GPIO   289.42m   3.76918nH   0.33086pF
AA13   PA22   GPIO   642.58m   8.06848nH   0.69500pF
W15   PA23   GPIO   363.76m   4.60302nH   0.48378pF
Y17   PA24   GPIO   434.94m   5.16888nH   0.38980pF
V17   PA25   GPIO   291.76m   3.87382nH   0.40914pF
AA14   PA26   GPIO   604.53m   7.77026nH   0.60313pF
AA15   PA27   GPIO   555.4m   7.33430nH   0.53893pF
T17   PA28   GPIO   207.58m   2.33617nH   0.27332pF
AA16   PA29   GPIO   522.79m   6.81447nH   0.50987pF
R24   PA3   HSIO   266.06m   3.93809nH   0.31017pF
Y14   PA30   GPIO   493.74m   6.48404nH   0.64654pF
AA17   PA31   GPIO   475.73m   6.33691nH   0.41844pF
N20   PA4   HSIO   194.62m   2.33832nH   0.16996pF
N24   PA5   HSIO   315.31m   3.94299nH   0.17357pF
N22   PA6   HSIO   142.75m   2.18381nH   0.16424pF
N21   PA7   HSIO   200.42m   2.44509nH   0.19837pF
M25   PA8   HSIO   330.74m   4.53730nH   0.21832pF
L25   PA9   HSIO   355.32m   4.44154nH   0.25487pF
T18   PB0   GPIO   164.16m   1.90765nH   0.24343pF
AA18   PB1   GPIO   455.76m   6.15705nH   0.38575pF
R20   PB10   HSIO   176.16m   1.96049nH   0.09990pF
U25   PB11   HSIO   412.25m   5.45262nH   0.25557pF
V25   PB12   HSIO   333.64m   5.14805nH   0.35841pF
U22   PB13   HSIO   349.66m   4.31581nH   0.16718pF
W25   PB14   HSIO_PB14_PB15   394.81m   5.76010nH   0.45695pF
W24   PB15   HSIO_PB14_PB15   395.15m   5.66340nH   0.44485pF
U23   PB16   HSIO   288.69m   4.19276nH   0.33502pF
T25   PB17   HSIO   394.22m   5.20542nH   0.24128pF
R23   PB18   HSIO   315.59m   3.84221nH   0.25278pF
R21   PB19   HSIO   234.73m   2.88905nH   0.27975pF
Y19   PB2   GPIO   390.77m   5.06368nH   0.43817pF
U24   PB20   HSIO   365.69m   4.90628nH   0.24291pF
R25   PB21   GPIO   374.14m   4.96046nH   0.24213pF
L20   PB22   GPIO   76.47m   1.09023nH   0.12740pF
K25   PB23   GPIO   344.67m   4.57424nH   0.25315pF
L23   PB24   GPIO   303.6m   3.45311nH   0.19627pF
L22   PB25   GPIO   165.25m   2.04735nH   0.13250pF
L24   PB26   GPIO   352.98m   4.10570nH   0.25823pF
L21   PB27   GPIO   176.86m   2.02689nH   0.17494pF
C17   PB28   GPIO   306.71m   4.93434nH   0.28947pF
A19   PB29   HSIO   433.14m   6.19293nH   0.40173pF
AA19   PB3   GPIO   467.53m   6.16495nH   0.38168pF
A16   PB30   HSIO   521.26m   7.15334nH   0.41342pF
B19   PB31   HSIO   420.9m   5.62206nH   0.33138pF
U19   PB4   GPIO   268.22m   3.27944nH   0.38039pF
W19   PB5   GPIO   380.78m   4.95538nH   0.29062pF
W20   PB6   GPIO   324.97m   4.93924nH   0.34942pF
W17   PB7   GPIO   421.12m   5.68345nH   0.35385pF
W21   PB8   GPIO   300.6m   4.99811nH   0.27998pF
Y25   PB9   HSIO   536.25m   7.27073nH   0.25608pF
A18   PC0   HSIO   399.36m   6.03383nH   0.41807pF
A17   PC1   HSIO   432.68m   6.40261nH   0.50595pF
J14   PC10   GPIO   79.8m   0.90202nH   0.10211pF
F11   PC11   GPIO   266.59m   3.60559nH   0.32602pF
B4   PC12   GPIO   804.12m   11.11459nH   1.02610pF
D13   PC13   GPIO   306m   4.06878nH   0.38292pF
E15   PC14   GPIO   380.34m   4.28814nH   0.22865pF
G15   PC15   GPIO   119.78m   1.37755nH   0.16159pF
A9   PC16   GPIO   617.14m   9.13844nH   0.63767pF
F15   PC17   GPIO   141.06m   1.74561nH   0.18030pF
A8   PC18   GPIO   683.53m   9.65039nH   0.82558pF
E13   PC19   GPIO   220.68m   3.06909nH   0.26910pF
B17   PC2   HSIO   406.2m   5.85122nH   0.32339pF
A7   PC20   GPIO   734.37m   10.15382nH   0.90354pF
C9   PC21   GPIO   452.89m   6.74525nH   0.59737pF
A6   PC22   GPIO   775.7m   10.68276nH   0.93074pF
A5   PC23   GPIO   801.32m   11.00360nH   0.95269pF
C11   PC24   GPIO   366.58m   5.13785nH   0.47578pF
D7   PC25   GPIO   633.05m   8.55201nH   0.72695pF
E11   PC26   GPIO   298.33m   3.84352nH   0.36058pF
B5   PC27   GPIO   716.55m   10.05698nH   0.86149pF
H15   PC28   GPIO   74.89m   1.14512nH   0.12292pF
B7   PC29   GPIO   603.71m   8.37410nH   0.67991pF
D2   PC3   GPIO   810.47m   12.43498nH   0.92143pF
A3   PC30   GPIO   923.32m   12.74463nH   1.09335pF
D11   PC31   GPIO   321.62m   4.46276nH   0.44734pF
H13   PC4   GPIO   150.66m   1.66918nH   0.29434pF
C7   PC5   GPIO   174.55m   1.86922nH   0.27923pF
H11   PC6   GPIO   227.14m   2.95050nH   0.24572pF
J13   PC7   GPIO   69.66m   1.05033nH   0.12002pF
D1   PC8   GPIO   930.28m   13.12954nH   1.19661pF
C5   PC9   GPIO   720.35m   9.82279nH   0.96449pF
B1   PD0   GPIO   1005.15m   14.18296nH   0.99143pF
F13   PD1   GPIO   156.85m   2.23145nH   0.22030pF
J24   PD10   GPIO   214.27m   3.62558nH   0.27667pF
H25   PD11   GPIO   414.83m   5.35862nH   0.31881pF
L19   PD12   GPIO   227.25m   2.71737nH   0.24146pF
K19   PD13   GPIO   201.47m   2.42217nH   0.27731pF
J23   PD14   GPIO   320.24m   3.48978nH   0.20001pF
J18   PD15   GPIO   275.78m   3.15980nH   0.30633pF
G25   PD16   GPIO   397.09m   5.02558nH   0.31216pF
J20   PD17   GPIO   207.89m   2.18260nH   0.23766pF
F25   PD18   GPIO   443.54m   5.54404nH   0.39997pF
J21   PD19   GPIO   190.49m   2.26072nH   0.26570pF
E19   PD2   GPIO   250.64m   3.55447nH   0.21590pF
E25   PD20   GPIO   481.47m   6.10721nH   0.42188pF
J22   PD21   GPIO   212.15m   2.39099nH   0.20389pF
G24   PD22   GPIO   340.85m   4.38169nH   0.27897pF
G22   PD23   GPIO   242m   2.89911nH   0.26996pF
C25   PD24   GPIO   543.72m   7.25010nH   0.41749pF
G23   PD25   GPIO   212.76m   3.16983nH   0.23601pF
E23   PD26   GPIO   297.67m   4.20342nH   0.35038pF
B25   PD27   GPIO   575.73m   7.56175nH   0.44581pF
C21   PD28   GPIO   308.48m   4.97565nH   0.42609pF
C24   PD29   GPIO   500.76m   6.56252nH   0.43019pF
A20   PD3   HSIO   470.39m   6.82918nH   0.30763pF
E22   PD30   GPIO   282.39m   3.89181nH   0.32173pF
E24   PD31   GPIO   398.88m   5.01128nH   0.31440pF
D19   PD4   HSIO   374.49m   5.32319nH   0.28953pF
C19   PD5   HSIO   399.99m   5.72152nH   0.34737pF
G17   PD6   HSIO   304.07m   4.00745nH   0.25423pF
F17   PD7   HSIO   285.01m   3.53672nH   0.23820pF
E17   PD8   HSIO   393.2m   4.83590nH   0.28823pF
J25   PD9   GPIO   397.67m   5.12623nH   0.30384pF
D25   PE0   GPIO   610.67m   7.76511nH   0.44538pF
G21   PE1   GPIO   106.95m   1.69502nH   0.16376pF
A23   PE2   GPIO   543.53m   7.86320nH   0.40061pF
B22   PE3   GPIO   475.68m   6.73555nH   0.39789pF
B21   PE4   GPIO   398.82m   5.78640nH   0.50658pF
A22   PE5   GPIO   546.48m   7.70094nH   0.46038pF
A21   PE6   GPIO   470.85m   6.76086nH   0.51314pF
G20   PE7   GPIO   77.39m   1.32565nH   0.10715pF
T1   DDRM_VDD   POWER
K7   DDRM_VDD   POWER
H6   DDRM_VDD   POWER
J6   DDRM_VDD   POWER
K6   DDRM_VDD   POWER
L6   DDRM_VDD   POWER
M7   DDRM_VDD   POWER
N6   DDRM_VDD   POWER
N5   DDRM_VDD   POWER
F6   DDRM_VDD   POWER
G6   DDRM_VDD   POWER
U2   DDRM_VDD   POWER
E9   DDRM_VDD   POWER
K9   DDRM_VDD   POWER
W9   DDRM_VDD   POWER
Y8   DDRM_VDD   POWER
E7   DDRM_VDD   POWER
F8   DDRM_VDD   POWER
W7   DDRM_VDD   POWER
AA7   DDRM_VDD   POWER
F5   DDRM_VDD   POWER
U5   DDRM_VDD   POWER
P6   DDRM_VDD   POWER
N8   DDRM_VDD   POWER
T6   DDRM_VDD   POWER
U7   DDRM_VDD   POWER
T8   DDRM_VDD   POWER
U9   DDRM_VDD   POWER
R9   DDRM_VDD   POWER
T10   DDRM_VDD   POWER
V6   DDRM_VDD   POWER
W6   DDRM_VDD   POWER
Y6   DDRM_VDD   POWER
A4   DDRM_VDD   POWER
B6   DDRM_VDD   POWER
J4   DDRM_VDD   POWER
K5   DDRM_VDD   POWER
R4   DDRM_VDD   POWER
R5   DDRM_VDD   POWER
N3   DDRM_VDD   POWER
U4   DDRM_VDD   POWER
Y4   DDRM_VDD   POWER
AA5   DDRM_VDD   POWER
E3   DDRM_VDD   POWER
F2   DDRM_VDD   POWER
L4   DDRM_VDD   POWER
W2   DDRM_VDD   POWER
AA3   DDRM_VDD   POWER
E1   DDRM_VDD   POWER
G1   DDRM_VDD   POWER
H2   DDRM_VDD   POWER
J2   DDRM_VDD   POWER
K1   DDRM_VDD   POWER
M1   DDRM_VDD   POWER
L2   DDRM_VDD   POWER
P1   DDRM_VDD   POWER
V1   DDRM_VDD   POWER
Y1   DDRM_VDD   POWER
R2   DDRM_VDD   POWER
H24   VDDIOP1   POWER
K18   VDDCPU   POWER
K24   VDDQSPI1   POWER
P20   VDDQSPI0   POWER
B18   VDDSDMMC1   POWER
M24   VDDSDMMC0   POWER
D24   VDDSDMMC2   POWER
J15   VDDANA   POWER
T20   VDDDPHY   POWER
U21   VDDDPHY   POWER
K16   VBAT   POWER
F16   VDDUTMI   POWER
B14   VDDUTMI   POWER
B12   VDDUTMI   POWER
B10   VDDUTMI   POWER
B8   VDDUTMI   POWER
R12   DDR_VREF   POWER
E4   DDR_VREF   POWER
G4   DDRM_ZQ   POWER
F14   VDDIN33   POWER
F12   VDDANA   POWER
D9   ADVREFP   POWER
F10   VDDANA   POWER
F21   VDDCPU   POWER
H20   VDDCPU   POWER
G19   VDDCPU   POWER
J19   VDDCPU   POWER
Y16   VDDIOP0   POWER
Y18   VDDIOP0   POWER
F24   VDDIOP1   POWER
G11   VDDCORE   POWER
L13   VDDCORE   POWER
M12   VDDCORE   POWER
T24   VDDCORE   POWER
P21   VDDCORE   POWER
K20   VDDCORE   POWER
N19   VDDCORE   POWER
V19   VDDCORE   POWER
N17   VDDCORE   POWER
J17   VDDCORE   POWER
K17   VDDCORE   POWER
T16   VDDCORE   POWER
T14   VDDCORE   POWER
H12   VDDCORE   POWER
K14   VDDIODDR   POWER
M14   VDDIODDR   POWER
N13   VDDIODDR   POWER
K12   VDDIODDR   POWER
P12   VDDIODDR   POWER
L10   VDDIODDR   POWER
L11   VDDIODDR   POWER
M10   VDDIODDR   POWER
N11   VDDIODDR   POWER
P10   VDDIODDR   POWER
L9   VDDIODDR   POWER
M9   VDDIODDR   POWER
P14   VDDIODDR   POWER
M16   VDDIODDR   POWER
N15   VDDIODDR   POWER
L15   VDDIODDR   POWER
R13   VDDIODDR   POWER
M11   GND   GND
N12   GND   GND
A25   GND   GND
AA25   GND   GND
B24   GND   GND
C23   GND   GND
P24   GND   GND
V24   GND   GND
W23   GND   GND
Y24   GND   GND
D22   GND   GND
D20   GND   GND
K21   GND   GND
M21   GND   GND
T21   GND   GND
R19   GND   GND
E18   GND   GND
L17   GND   GND
L18   GND   GND
M17   GND   GND
M18   GND   GND
N18   GND   GND
P18   GND   GND
J16   GND   GND
L16   GND   GND
K15   GND   GND
L14   GND   GND
M15   GND   GND
N14   GND   GND
U14   GND   GND
K13   GND   GND
M13   GND   GND
P13   GND   GND
L12   GND   GND
T12   GND   GND
U12   GND   GND
J10   GND   GND
K10   GND   GND
K11   GND   GND
N10   GND   GND
P11   GND   GND
R10   GND   GND
R11   GND   GND
T11   GND   GND
U10   GND   GND
W11   GND   GND
Y10   GND   GND
F9   GND   GND
G9   GND   GND
J9   GND   GND
N9   GND   GND
T9   GND   GND
V9   GND   GND
G7   GND   GND
H8   GND   GND
J7   GND   GND
K8   GND   GND
L7   GND   GND
L8   GND   GND
M8   GND   GND
N7   GND   GND
P8   GND   GND
R7   GND   GND
U8   GND   GND
V7   GND   GND
Y7   GND   GND
M6   GND   GND
R6   GND   GND
AA6   GND   GND
AA8   GND   GND
D4   GND   GND
E5   GND   GND
G5   GND   GND
H5   GND   GND
J5   GND   GND
L5   GND   GND
M5   GND   GND
N4   GND   GND
P5   GND   GND
T5   GND   GND
V4   GND   GND
W5   GND   GND
Y5   GND   GND
AA4   GND   GND
C3   GND   GND
G3   GND   GND
J3   GND   GND
L3   GND   GND
R3   GND   GND
U3   GND   GND
W3   GND   GND
A1   GND   GND
B2   GND   GND
E2   GND   GND
F1   GND   GND
G2   GND   GND
H1   GND   GND
J1   GND   GND
K2   GND   GND
L1   GND   GND
M2   GND   GND
N1   GND   GND
N2   GND   GND
P2   GND   GND
R1   GND   GND
T2   GND   GND
U1   GND   GND
V2   GND   GND
W1   GND   GND
Y2   GND   GND
AA1   GND   GND
E21   GND   GND
H21   GND   GND
U16   GND   GND
U18   GND   GND
F20   GND   GND
B16   GND   GND
Y12   GND   GND
V22   GNDDPHY   GND
V20   GNDDPHY   GND
H10   GNDANA   GND
H16   GNDIN33   GND
E14   GNDUTMI   GND
H18   GNDUTMI   GND
E12   GNDUTMI   GND
E10   GNDUTMI   GND
E8   GNDUTMI   GND
E16   GNDANA   GND
H14   GNDANA   GND
N16   GNDBAT   GND
AA23   MIPI_REXT   NC
AA20   MIPI_DP1   NC
Y20   MIPI_DN1   NC
Y21   MIPI_CLKN   NC
AA21   MIPI_CLKP   NC
AA22   MIPI_DP0   NC
Y22   MIPI_DN0   NC
C2   XIN   NC
C1   XOUT   NC
J12   DDR_ZQ   NC
R15   SHDN   NC
P15   LPM   NC
U11   TST   NC
V13   PIOBU0   NC
T15   PIOBU1   NC
V11   PIOBU2   NC
U13   PIOBU3   NC
AA9   XOUT32   NC
Y9   XIN32   NC
T13   JTAGSEL   NC
Y11   WKUP0   NC
A15   HHSC_DP   NC
B15   HHSC_DM   NC
A14   HHSC_RTUNE   NC
D17   HHSB_CC2   NC
C15   HHSB_CC1   NC
A13   HHSB_DP   NC
B13   HHSB_DM   NC
A12   HHSB_RTUNE   NC
D15   HHSA_CC2   NC
C13   HHSA_CC1   NC
A11   HHSA_DP   NC
B11   HHSA_DM   NC
A10   HHSA_RTUNE   NC
B20   SDMMC2_CAL   NC
F18   SDMMC1_CAL   NC
M20   SDMMC0_CAL   NC
R17   QSPI0_CAL   NC
B9   NRST_OUT   NC
G13   NRST   NC
|**********************DIFF PIN************************************************
[Diff pin]  inv_pin   vdiff   tdelay_typ  tdelay_min  tdelay_max
|QSPIO_SCK   QSPI0_SPCKN
W25   W24   NA   NA   NA   NA
|END COMPONENT SAMA7D65D1G_4UB ************************************************
|   Component SAMA7D54D2G_4UB
[Component]   SAMA7D54D2G_4UB
[Manufacturer]  Microchip Technology Inc.
[Package]
| variable   typ   min   max
R_pkg   536.25m   69.66m   1005.15m
L_pkg   7.56175nH   0.902nH   14.18296nH
C_pkg   0.64654pF   0.0999pF   1.19661pF
[Pin]   signal_name   model_name   R_pin   L_pin   C_pin
J11   AUDIOCLK   GPIO   204.37m   2.81045nH   0.17828pF
N23   PA0   HSIO   184.22m   3.00320nH   0.22360pF
P25   PA1   HSIO   367.61m   4.89885nH   0.25998pF
M19   PA10   HSIO   213.12m   2.71893nH   0.23736pF
N25   PA11   HSIO   360.07m   5.04795nH   0.25487pF
P16   PA12   GPIO   91.62m   1.23179nH   0.11922pF
AA10   PA13   GPIO   722.27m   9.59386nH   0.93024pF
AA11   PA14   GPIO   681.66m   9.07815nH   0.89312pF
V15   PA15   GPIO   271.1m   3.92355nH   0.40452pF
Y15   PA16   GPIO   452.63m   6.01560nH   0.52271pF
W13   PA17   GPIO   421.34m   5.73737nH   0.59045pF
Y13   PA18   GPIO   581.42m   7.70568nH   0.66684pF
U17   PA19   GPIO   212.21m   2.69146nH   0.34397pF
R22   PA2   GPIO   208.15m   3.04760nH   0.31144pF
AA12   PA20   GPIO   692.38m   8.99355nH   0.89771pF
U15   PA21   GPIO   291.44m   3.91147nH   0.35688pF
AA13   PA22   GPIO   653.78m   8.42096nH   0.87780pF
W15   PA23   GPIO   363.75m   4.75439nH   0.51580pF
Y17   PA24   GPIO   440.06m   5.44798nH   0.46980pF
V17   PA25   GPIO   289.52m   3.99296nH   0.44485pF
AA14   PA26   GPIO   610.01m   8.09459nH   0.73597pF
AA15   PA27   GPIO   563.35m   7.62110nH   0.65684pF
T17   PA28   GPIO   208.47m   2.45416nH   0.29258pF
AA16   PA29   GPIO   530.28m   7.08405nH   0.62403pF
R24   PA3   HSIO   267.32m   4.07277nH   0.34321pF
Y14   PA30   GPIO   493.68m   6.64805nH   0.69653pF
AA17   PA31   GPIO   483.2m   6.59602nH   0.51819pF
N20   PA4   HSIO   211.78m   2.71021nH   0.18941pF
N24   PA5   HSIO   318.83m   4.19203nH   0.19712pF
N22   PA6   HSIO   144.53m   2.28837nH   0.18292pF
N21   PA7   HSIO   198.85m   2.55917nH   0.21468pF
M25   PA8   HSIO   336.22m   4.78941nH   0.25755pF
L25   PA9   HSIO   359.82m   4.71419nH   0.29846pF
T18   PB0   GPIO   164.52m   2.02096nH   0.26639pF
AA18   PB1   GPIO   460.67m   6.41465nH   0.47515pF
R20   PB10   HSIO   176.1m   2.06678nH   0.10720pF
U25   PB11   HSIO   415.96m   5.72272nH   0.28700pF
V25   PB12   HSIO   348.99m   5.41917nH   0.42926pF
U22   PB13   HSIO   350.38m   4.55152nH   0.18428pF
W25   PB14   HSIO_PB14_PB15   408.07m   6.03944nH   0.55636pF
W24   PB15   HSIO_PB14_PB15   406.82m   5.92914nH   0.54434pF
U23   PB16   HSIO   289.67m   4.32413nH   0.39131pF
T25   PB17   HSIO   398.13m   5.47086nH   0.27418pF
R23   PB18   HSIO   320.85m   4.09852nH   0.28349pF
R21   PB19   HSIO   232.18m   3.00450nH   0.31614pF
Y19   PB2   GPIO   390.93m   5.20856nH   0.49878pF
U24   PB20   HSIO   368.77m   5.16591nH   0.28293pF
R25   PB21   GPIO   379.42m   5.22797nH   0.26958pF
L20   PB22   GPIO   97.74m   1.36915nH   0.15411pF
K25   PB23   GPIO   355.26m   4.82212nH   0.29910pF
L23   PB24   GPIO   310.37m   3.69609nH   0.23072pF
L22   PB25   GPIO   165.16m   2.15470nH   0.15038pF
L24   PB26   GPIO   362.37m   4.36350nH   0.30181pF
L21   PB27   GPIO   180.65m   2.16277nH   0.20050pF
C17   PB28   GPIO   339.74m   5.17461nH   0.34326pF
A19   PB29   HSIO   445.42m   6.44698nH   0.47886pF
AA19   PB3   GPIO   469.63m   6.42629nH   0.45686pF
A16   PB30   HSIO   529.87m   7.42276nH   0.51074pF
B19   PB31   HSIO   424.71m   5.87605nH   0.38221pF
U19   PB4   GPIO   267.37m   3.37900nH   0.44571pF
W19   PB5   GPIO   385.62m   5.19297nH   0.34252pF
W20   PB6   GPIO   323.83m   5.04304nH   0.41284pF
W17   PB7   GPIO   420.62m   5.92907nH   0.37455pF
W21   PB8   GPIO   301.15m   5.09781nH   0.31010pF
Y25   PB9   HSIO   534.74m   7.54487nH   0.28058pF
A18   PC0   HSIO   422.24m   6.29430nH   0.49935pF
A17   PC1   HSIO   453.6m   6.66773nH   0.64384pF
J14   PC10   GPIO   101.35m   1.16297nH   0.11896pF
F11   PC11   GPIO   266.16m   3.72995nH   0.35918pF
B4   PC12   GPIO   815.75m   11.48404nH   1.30870pF
D13   PC13   GPIO   322.37m   4.33760nH   0.40393pF
E15   PC14   GPIO   385.33m   4.52765nH   0.24655pF
G15   PC15   GPIO   138.18m   1.63740nH   0.17864pF
A9   PC16   GPIO   622.44m   9.42766nH   0.77302pF
F15   PC17   GPIO   151.76m   1.97978nH   0.21064pF
A8   PC18   GPIO   691.3m   9.95645nH   1.05674pF
E13   PC19   GPIO   234.01m   3.31000nH   0.32380pF
B17   PC2   HSIO   413.06m   6.09349nH   0.39979pF
A7   PC20   GPIO   742.72m   10.47919nH   1.14721pF
C9   PC21   GPIO   465.48m   7.04796nH   0.74569pF
A6   PC22   GPIO   785.06m   11.03289nH   1.18231pF
A5   PC23   GPIO   812.14m   11.37388nH   1.24233pF
C11   PC24   GPIO   381.88m   5.40635nH   0.59582pF
D7   PC25   GPIO   640.19m   8.87048nH   0.90724pF
E11   PC26   GPIO   299.88m   3.97812nH   0.41657pF
B5   PC27   GPIO   726.06m   10.41563nH   1.11878pF
H15   PC28   GPIO   94.81m   1.42675nH   0.14128pF
B7   PC29   GPIO   613.23m   8.69286nH   0.85867pF
D2   PC3   GPIO   825.32m   12.80346nH   1.10347pF
A3   PC30   GPIO   933.57m   13.14667nH   1.38662pF
D11   PC31   GPIO   336.38m   4.71594nH   0.54856pF
H13   PC4   GPIO   151.92m   1.77884nH   0.33992pF
C7   PC5   GPIO   619.29m   8.70687nH   0.93329pF
H11   PC6   GPIO   225.01m   3.06748nH   0.28082pF
J13   PC7   GPIO   83.07m   1.27179nH   0.14589pF
D1   PC8   GPIO   944.45m   13.52111nH   1.49780pF
C5   PC9   GPIO   731.81m   10.18113nH   1.24491pF
B1   PD0   GPIO   1010.57m   14.62217nH   1.22754pF
F13   PD1   GPIO   168.36m   2.45453nH   0.25194pF
J24   PD10   GPIO   217.49m   3.73102nH   0.30437pF
H25   PD11   GPIO   422.04m   5.61424nH   0.37505pF
L19   PD12   GPIO   226.75m   2.90104nH   0.28541pF
K19   PD13   GPIO   203.95m   2.60016nH   0.33729pF
J23   PD14   GPIO   325.87m   3.73195nH   0.23265pF
J18   PD15   GPIO   272.66m   3.33870nH   0.37231pF
G25   PD16   GPIO   402.33m   5.29670nH   0.37054pF
J20   PD17   GPIO   214.15m   2.33946nH   0.27655pF
F25   PD18   GPIO   448.85m   5.82335nH   0.48495pF
J21   PD19   GPIO   189.48m   2.37032nH   0.29192pF
E19   PD2   GPIO   255.09m   3.77440nH   0.23367pF
E25   PD20   GPIO   488.22m   6.39311nH   0.51021pF
J22   PD21   GPIO   228.23m   2.74018nH   0.23725pF
G24   PD22   GPIO   346.66m   4.63161nH   0.33645pF
G22   PD23   GPIO   259.8m   3.27917nH   0.29603pF
C25   PD24   GPIO   550.76m   7.56003nH   0.50027pF
G23   PD25   GPIO   209.14m   3.28720nH   0.25752pF
E23   PD26   GPIO   299.38m   4.33092nH   0.43253pF
B25   PD27   GPIO   581.64m   7.87702nH   0.55123pF
C21   PD28   GPIO   325.77m   5.22796nH   0.54604pF
C24   PD29   GPIO   505.62m   6.85470nH   0.52764pF
A20   PD3   HSIO   474.47m   7.07534nH   0.35568pF
E22   PD30   GPIO   282.02m   4.01209nH   0.38563pF
E24   PD31   GPIO   400.68m   5.27580nH   0.37733pF
D19   PD4   HSIO   376.1m   5.54302nH   0.33236pF
C19   PD5   HSIO   402.91m   5.94936nH   0.40738pF
G17   PD6   HSIO   311.7m   4.27595nH   0.27528pF
F17   PD7   HSIO   275.95m   3.78749nH   0.25908pF
E17   PD8   HSIO   398.63m   5.10164nH   0.31397pF
J25   PD9   GPIO   407.93m   5.37402nH   0.36594pF
D25   PE0   GPIO   614.05m   8.10103nH   0.50584pF
G21   PE1   GPIO   120.58m   1.91086nH   0.20438pF
A23   PE2   GPIO   546.23m   8.16243nH   0.47350pF
B22   PE3   GPIO   479.53m   7.01251nH   0.47574pF
B21   PE4   GPIO   397.57m   5.92674nH   0.63729pF
A22   PE5   GPIO   551.47m   7.99293nH   0.57759pF
A21   PE6   GPIO   472.38m   6.92005nH   0.63780pF
G20   PE7   GPIO   92.52m   1.54449nH   0.12395pF
T1   DDRM_VDD   POWER
K7   DDRM_VDD   POWER
H6   DDRM_VDD   POWER
J6   DDRM_VDD   POWER
K6   DDRM_VDD   POWER
L6   DDRM_VDD   POWER
M7   DDRM_VDD   POWER
N6   DDRM_VDD   POWER
N5   DDRM_VDD   POWER
F6   DDRM_VDD   POWER
G6   DDRM_VDD   POWER
U2   DDRM_VDD   POWER
E9   DDRM_VDD   POWER
K9   DDRM_VDD   POWER
W9   DDRM_VDD   POWER
Y8   DDRM_VDD   POWER
E7   DDRM_VDD   POWER
F8   DDRM_VDD   POWER
W7   DDRM_VDD   POWER
AA7   DDRM_VDD   POWER
F5   DDRM_VDD   POWER
U5   DDRM_VDD   POWER
P6   DDRM_VDD   POWER
N8   DDRM_VDD   POWER
T6   DDRM_VDD   POWER
U7   DDRM_VDD   POWER
T8   DDRM_VDD   POWER
U9   DDRM_VDD   POWER
R9   DDRM_VDD   POWER
T10   DDRM_VDD   POWER
V6   DDRM_VDD   POWER
W6   DDRM_VDD   POWER
Y6   DDRM_VDD   POWER
A4   DDRM_VDD   POWER
B6   DDRM_VDD   POWER
J4   DDRM_VDD   POWER
K5   DDRM_VDD   POWER
R4   DDRM_VDD   POWER
R5   DDRM_VDD   POWER
N3   DDRM_VDD   POWER
U4   DDRM_VDD   POWER
Y4   DDRM_VDD   POWER
AA5   DDRM_VDD   POWER
E3   DDRM_VDD   POWER
F2   DDRM_VDD   POWER
L4   DDRM_VDD   POWER
W2   DDRM_VDD   POWER
AA3   DDRM_VDD   POWER
E1   DDRM_VDD   POWER
G1   DDRM_VDD   POWER
H2   DDRM_VDD   POWER
J2   DDRM_VDD   POWER
K1   DDRM_VDD   POWER
M1   DDRM_VDD   POWER
L2   DDRM_VDD   POWER
P1   DDRM_VDD   POWER
V1   DDRM_VDD   POWER
Y1   DDRM_VDD   POWER
R2   DDRM_VDD   POWER
H24   VDDIOP1   POWER
K18   VDDCPU   POWER
K24   VDDQSPI1   POWER
P20   VDDQSPI0   POWER
B18   VDDSDMMC1   POWER
M24   VDDSDMMC0   POWER
D24   VDDSDMMC2   POWER
J15   VDDANA   POWER
T20   VDDDPHY   POWER
U21   VDDDPHY   POWER
K16   VBAT   POWER
F16   VDDUTMI   POWER
B14   VDDUTMI   POWER
B12   VDDUTMI   POWER
B10   VDDUTMI   POWER
B8   VDDUTMI   POWER
R12   DDR_VREF   POWER
E4   DDR_VREF   POWER
G4   DDRM_ZQ   POWER
F14   VDDIN33   POWER
F12   VDDANA   POWER
D9   ADVREFP   POWER
F10   VDDANA   POWER
F21   VDDCPU   POWER
H20   VDDCPU   POWER
G19   VDDCPU   POWER
J19   VDDCPU   POWER
Y16   VDDIOP0   POWER
Y18   VDDIOP0   POWER
F24   VDDIOP1   POWER
G11   VDDCORE   POWER
L13   VDDCORE   POWER
M12   VDDCORE   POWER
T24   VDDCORE   POWER
P21   VDDCORE   POWER
K20   VDDCORE   POWER
N19   VDDCORE   POWER
V19   VDDCORE   POWER
N17   VDDCORE   POWER
J17   VDDCORE   POWER
K17   VDDCORE   POWER
T16   VDDCORE   POWER
T14   VDDCORE   POWER
H12   VDDCORE   POWER
K14   VDDIODDR   POWER
M14   VDDIODDR   POWER
N13   VDDIODDR   POWER
K12   VDDIODDR   POWER
P12   VDDIODDR   POWER
L10   VDDIODDR   POWER
L11   VDDIODDR   POWER
M10   VDDIODDR   POWER
N11   VDDIODDR   POWER
P10   VDDIODDR   POWER
L9   VDDIODDR   POWER
M9   VDDIODDR   POWER
P14   VDDIODDR   POWER
M16   VDDIODDR   POWER
N15   VDDIODDR   POWER
L15   VDDIODDR   POWER
R13   VDDIODDR   POWER
M11   GND   GND
N12   GND   GND
A25   GND   GND
AA25   GND   GND
B24   GND   GND
C23   GND   GND
P24   GND   GND
V24   GND   GND
W23   GND   GND
Y24   GND   GND
D22   GND   GND
D20   GND   GND
K21   GND   GND
M21   GND   GND
T21   GND   GND
R19   GND   GND
E18   GND   GND
L17   GND   GND
L18   GND   GND
M17   GND   GND
M18   GND   GND
N18   GND   GND
P18   GND   GND
J16   GND   GND
L16   GND   GND
K15   GND   GND
L14   GND   GND
M15   GND   GND
N14   GND   GND
U14   GND   GND
K13   GND   GND
M13   GND   GND
P13   GND   GND
L12   GND   GND
T12   GND   GND
U12   GND   GND
J10   GND   GND
K10   GND   GND
K11   GND   GND
N10   GND   GND
P11   GND   GND
R10   GND   GND
R11   GND   GND
T11   GND   GND
U10   GND   GND
W11   GND   GND
Y10   GND   GND
F9   GND   GND
G9   GND   GND
J9   GND   GND
N9   GND   GND
T9   GND   GND
V9   GND   GND
G7   GND   GND
H8   GND   GND
J7   GND   GND
K8   GND   GND
L7   GND   GND
L8   GND   GND
M8   GND   GND
N7   GND   GND
P8   GND   GND
R7   GND   GND
U8   GND   GND
V7   GND   GND
Y7   GND   GND
M6   GND   GND
R6   GND   GND
AA6   GND   GND
AA8   GND   GND
D4   GND   GND
E5   GND   GND
G5   GND   GND
H5   GND   GND
J5   GND   GND
L5   GND   GND
M5   GND   GND
N4   GND   GND
P5   GND   GND
T5   GND   GND
V4   GND   GND
W5   GND   GND
Y5   GND   GND
AA4   GND   GND
C3   GND   GND
G3   GND   GND
J3   GND   GND
L3   GND   GND
R3   GND   GND
U3   GND   GND
W3   GND   GND
A1   GND   GND
B2   GND   GND
E2   GND   GND
F1   GND   GND
G2   GND   GND
H1   GND   GND
J1   GND   GND
K2   GND   GND
L1   GND   GND
M2   GND   GND
N1   GND   GND
N2   GND   GND
P2   GND   GND
R1   GND   GND
T2   GND   GND
U1   GND   GND
V2   GND   GND
W1   GND   GND
Y2   GND   GND
AA1   GND   GND
E21   GND   GND
H21   GND   GND
U16   GND   GND
U18   GND   GND
F20   GND   GND
B16   GND   GND
Y12   GND   GND
V22   GNDDPHY   GND
V20   GNDDPHY   GND
H10   GNDANA   GND
H16   GNDIN33   GND
E14   GNDUTMI   GND
H18   GNDUTMI   GND
E12   GNDUTMI   GND
E10   GNDUTMI   GND
E8   GNDUTMI   GND
E16   GNDANA   GND
H14   GNDANA   GND
N16   GNDBAT   GND
AA23   MIPI_REXT   NC
AA20   MIPI_DP1   NC
Y20   MIPI_DN1   NC
Y21   MIPI_CLKN   NC
AA21   MIPI_CLKP   NC
AA22   MIPI_DP0   NC
Y22   MIPI_DN0   NC
C2   XIN   NC
C1   XOUT   NC
J12   DDR_ZQ   NC
R15   SHDN   NC
P15   LPM   NC
U11   TST   NC
V13   PIOBU0   NC
T15   PIOBU1   NC
V11   PIOBU2   NC
U13   PIOBU3   NC
AA9   XOUT32   NC
Y9   XIN32   NC
T13   JTAGSEL   NC
Y11   WKUP0   NC
A15   HHSC_DP   NC
B15   HHSC_DM   NC
A14   HHSC_RTUNE   NC
D17   HHSB_CC2   NC
C15   HHSB_CC1   NC
A13   HHSB_DP   NC
B13   HHSB_DM   NC
A12   HHSB_RTUNE   NC
D15   HHSA_CC2   NC
C13   HHSA_CC1   NC
A11   HHSA_DP   NC
B11   HHSA_DM   NC
A10   HHSA_RTUNE   NC
B20   SDMMC2_CAL   NC
F18   SDMMC1_CAL   NC
M20   SDMMC0_CAL   NC
R17   QSPI0_CAL   NC
B9   NRST_OUT   NC
G13   NRST   NC
|**********************DIFF PIN************************************************
[Diff pin]  inv_pin   vdiff   tdelay_typ  tdelay_min  tdelay_max
|QSPIO_SCK   QSPI0_SPCKN
W25   W24   NA   NA   NA   NA
|END COMPONENT SAMA7D65D2G_4UB ************************************************
|   Component SAMA7D54D4G4UB
[Component]   SAMA7D54D4G_4UB
[Manufacturer]  Microchip Technology Inc.
[Package]
| variable   typ   min   max
R_pkg   0.58240   0.10439   1.69438
L_pkg   5.21038nH   0.54825nH   16.17902nH
C_pkg   0.62813pF   0.21342pF   1.69526pF
[Pin]   signal_name   model_name   R_pin   L_pin   C_pin
J11   AUDIOCLK   GPIO   0.28101   2.52786nH   0.35207pF
N23   PA0   HSIO   0.31178   2.75925nH   0.37743pF
P25   PA1   HSIO   0.53852   4.62156nH   0.47893pF
M19   PA10   HSIO   0.29856   1.96101nH   0.39032pF
N25   PA11   HSIO   0.52492   4.75844nH   0.46796pF
P16   PA12   GPIO   0.10587   0.64265nH   0.21370pF
AA10   PA13   GPIO   1.11603   10.17511nH   1.13738pF
AA11   PA14   GPIO   1.06917   9.52857nH   1.10042pF
V15   PA15   GPIO   0.42492   3.85930nH   0.60098pF
Y15   PA16   GPIO   0.68661   5.83925nH   0.78327pF
W13   PA17   GPIO   0.65336   6.05181nH   0.78212pF
Y13   PA18   GPIO   0.89074   7.82802nH   0.95874pF
U17   PA19   GPIO   0.31138   2.42447nH   0.51254pF
R22   PA2   GPIO   0.3208   2.76255nH   0.50549pF
AA12   PA20   GPIO   1.0781   9.35948nH   1.13017pF
U15   PA21   GPIO   0.43187   3.54319nH   0.59386pF
AA13   PA22   GPIO   1.00808   8.64924nH   1.13275pF
W15   PA23   GPIO   0.54729   4.88666nH   0.70991pF
Y17   PA24   GPIO   0.64578   5.19094nH   0.70332pF
V17   PA25   GPIO   0.42437   3.83557nH   0.61518pF
AA14   PA26   GPIO   0.92259   8.21748nH   0.97275pF
AA15   PA27   GPIO   0.84052   7.62431nH   0.88762pF
T17   PA28   GPIO   0.28736   2.02958nH   0.48319pF
AA16   PA29   GPIO   0.78503   6.98442nH   0.89028pF
R24   PA3   HSIO   0.44696   4.04220nH   0.51849pF
Y14   PA30   GPIO   0.74601   7.09147nH   0.93137pF
AA17   PA31   GPIO   0.73157   6.45264nH   0.77661pF
N20   PA4   HSIO   0.2482   1.90222nH   0.37687pF
N24   PA5   HSIO   0.44405   3.73581nH   0.36706pF
N22   PA6   HSIO   0.24158   1.90915nH   0.34817pF
N21   PA7   HSIO   0.27218   2.09279nH   0.38414pF
M25   PA8   HSIO   0.50452   4.47861nH   0.43650pF
L25   PA9   HSIO   0.52601   4.41735nH   0.48907pF
T18   PB0   GPIO   0.2308   1.61701nH   0.43861pF
AA18   PB1   GPIO   0.70832   6.25170nH   0.74410pF
R20   PB10   HSIO   0.21769   1.59217nH   0.25914pF
U25   PB11   HSIO   0.61816   5.60958nH   0.50880pF
V25   PB12   HSIO   0.56513   5.68557nH   0.54077pF
U22   PB13   HSIO   0.47214   3.96411nH   0.46641pF
W25   PB14   HSIO_PB14_PB15  0.64321   6.25682nH   0.68478pF
W24   PB15   HSIO_PB14_PB15  0.60893   5.99612nH   0.68269pF
U23   PB16   HSIO   0.44545   4.27837nH   0.57883pF
T25   PB17   HSIO   0.58921   5.27983nH   0.49568pF
R23   PB18   HSIO   0.44291   3.57844nH   0.50112pF
R21   PB19   HSIO   0.31294   2.59540nH   0.47672pF
Y19   PB2   GPIO   0.58433   5.35148nH   0.77131pF
U24   PB20   HSIO   0.54481   4.89857nH   0.48716pF
R25   PB21   GPIO   0.56628   4.98190nH   0.51701pF
L20   PB22   GPIO   0.13173   0.75782nH   0.26025pF
K25   PB23   GPIO   0.50719   4.47864nH   0.51709pF
L23   PB24   GPIO   0.39042   3.06827nH   0.44053pF
L22   PB25   GPIO   0.22905   1.73549nH   0.31144pF
L24   PB26   GPIO   0.47724   3.86703nH   0.53045pF
L21   PB27   GPIO   0.24809   1.51867nH   0.38860pF
C17   PB28   GPIO   0.50542   4.85084nH   0.61155pF
A19   PB29   HSIO   0.67458   6.45640nH   0.71023pF
AA19   PB3   GPIO   0.71053   6.30617nH   0.72803pF
A16   PB30   HSIO   0.78596   7.36002nH   0.78695pF
B19   PB31   HSIO   0.63545   5.62603nH   0.64986pF
U19   PB4   GPIO   0.37568   3.05075nH   0.63572pF
W19   PB5   GPIO   0.54753   4.73922nH   0.58224pF
W20   PB6   GPIO   0.50048   4.96216nH   0.68680pF
W17   PB7   GPIO   0.59968   5.55885nH   0.62293pF
W21   PB8   GPIO   0.49169   5.05954nH   0.58695pF
Y25   PB9   HSIO   0.76807   7.56778nH   0.52672pF
A18   PC0   HSIO   0.67514   6.29633nH   0.67601pF
A17   PC1   HSIO   0.70816   6.66325nH   0.81179pF
J14   PC10   GPIO   0.10439   0.54825nH   0.21342pF
F11   PC11   GPIO   0.38064   3.60031nH   0.49824pF
B4   PC12   GPIO   1.31965   12.30747nH   1.49351pF
D13   PC13   GPIO   0.44734   4.16840nH   0.49685pF
E15   PC14   GPIO   0.48445   3.82217nH   0.57449pF
G15   PC15   GPIO   0.15838   0.94628nH   0.31349pF
A9   PC16   GPIO   1.0511   9.29690nH   1.08080pF
F15   PC17   GPIO   0.19535   1.47661nH   0.36803pF
A8   PC18   GPIO   1.15618   9.99365nH   1.24729pF
E13   PC19   GPIO   0.33292   2.96107nH   0.47000pF
B17   PC2   HSIO   0.64134   5.77831nH   0.66213pF
A7   PC20   GPIO   1.24366   10.73460nH   1.33219pF
C9   PC21   GPIO   0.77393   7.20977nH   0.96535pF
A6   PC22   GPIO   1.31923   11.52858nH   1.38373pF
A5   PC23   GPIO   1.38301   12.11602nH   1.41259pF
C11   PC24   GPIO   0.58369   5.33023nH   0.79248pF
D7   PC25   GPIO   0.97202   9.08046nH   1.12992pF
E11   PC26   GPIO   0.41742   3.97181nH   0.53673pF
B5   PC27   GPIO   1.19434   11.12188nH   1.28624pF
H15   PC28   GPIO   0.13089   0.81954nH   0.25147pF
B7   PC29   GPIO   0.9808   9.06772nH   1.07730pF
D2   PC3   GPIO   1.35577   13.78447nH   1.47384pF
A3   PC30   GPIO   1.57367   14.26251nH   1.57571pF
D11   PC31   GPIO   0.49141   4.57685nH   0.67567pF
H13   PC4   GPIO   0.20275   1.14840nH   0.97295pF
C7   PC5   GPIO   0.96262   8.97857nH   1.16283pF
H11   PC6   GPIO   0.31521   2.79972nH   0.45173pF
J13   PC7   GPIO   0.11301   0.83843nH   0.26568pF
D1   PC8   GPIO   1.51899   14.74362nH   1.69526pF
C5   PC9   GPIO   1.17532   10.76201nH   1.38467pF
B1   PD0   GPIO   1.69438   16.17902nH   1.48218pF
F13   PD1   GPIO   0.23484   2.03632nH   0.37798pF
J24   PD10   GPIO   0.37979   3.60681nH   0.46845pF
H25   PD11   GPIO   0.58352   5.34266nH   0.56233pF
L19   PD12   GPIO   0.32158   1.94084nH   0.44044pF
K19   PD13   GPIO   0.28993   1.69646nH   0.48338pF
J23   PD14   GPIO   0.40384   3.08369nH   0.47119pF
J18   PD15   GPIO   0.36764   2.48663nH   0.56064pF
G25   PD16   GPIO   0.59529   5.04611nH   0.62061pF
J20   PD17   GPIO   0.27838   1.53480nH   0.46077pF
F25   PD18   GPIO   0.64618   5.65319nH   0.72362pF
J21   PD19   GPIO   0.25668   1.80736nH   0.49381pF
E19   PD2   GPIO   0.36776   3.29224nH   0.48583pF
E25   PD20   GPIO   0.72101   6.33368nH   0.79641pF
J22   PD21   GPIO   0.27096   2.02372nH   0.43017pF
G24   PD22   GPIO   0.50416   4.21861nH   0.55268pF
G22   PD23   GPIO   0.34357   2.65781nH   0.48270pF
C25   PD24   GPIO   0.83745   7.78482nH   0.73745pF
G23   PD25   GPIO   0.35068   3.07665nH   0.42610pF
E23   PD26   GPIO   0.45948   4.21494nH   0.61267pF
B25   PD27   GPIO   0.88548   8.16360nH   0.78512pF
C21   PD28   GPIO   0.51793   5.22982nH   0.71048pF
C24   PD29   GPIO   0.76572   6.85959nH   0.81121pF
A20   PD3   HSIO   0.7308   6.89024nH   0.66797pF
E22   PD30   GPIO   0.4197   3.80676nH   0.55099pF
E24   PD31   GPIO   0.5876   4.98476nH   0.63722pF
D19   PD4   HSIO   0.52723   4.98639nH   0.59710pF
C19   PD5   HSIO   0.5858   5.51832nH   0.70015pF
G17   PD6   HSIO   0.416   3.60139nH   0.49278pF
F17   PD7   HSIO   0.38357   3.14835nH   0.51882pF
E17   PD8   HSIO   0.5373   4.35700nH   0.63381pF
J25   PD9   GPIO   0.55783   5.02966nH   0.59583pF
D25   PE0   GPIO   0.87793   8.31262nH   0.78857pF
G21   PE1   GPIO   0.1821   1.51851nH   0.31515pF
A23   PE2   GPIO   0.85467   8.33539nH   0.78093pF
B22   PE3   GPIO   0.72344   6.92953nH   0.72273pF
B21   PE4   GPIO   0.61532   6.04337nH   0.75927pF
A22   PE5   GPIO   0.83244   8.10492nH   0.82195pF
A21   PE6   GPIO   0.7355   7.24693nH   0.79457pF
G20   PE7   GPIO   0.13364   1.12103nH   0.24162pF
T1   DDRM_VDD   POWER
K7   DDRM_VDD   POWER
H6   DDRM_VDD   POWER
J6   DDRM_VDD   POWER
K6   DDRM_VDD   POWER
L6   DDRM_VDD   POWER
M7   DDRM_VDD   POWER
N6   DDRM_VDD   POWER
N5   DDRM_VDD   POWER
F6   DDRM_VDD   POWER
G6   DDRM_VDD   POWER
U2   DDRM_VDD   POWER
E9   DDRM_VDD   POWER
K9   DDRM_VDD   POWER
W9   DDRM_VDD   POWER
Y8   DDRM_VDD   POWER
E7   DDRM_VDD   POWER
F8   DDRM_VDD   POWER
W7   DDRM_VDD   POWER
AA7   DDRM_VDD   POWER
F5   DDRM_VDD   POWER
U5   DDRM_VDD   POWER
P6   DDRM_VDD   POWER
N8   DDRM_VDD   POWER
T6   DDRM_VDD   POWER
U7   DDRM_VDD   POWER
T8   DDRM_VDD   POWER
U9   DDRM_VDD   POWER
R9   DDRM_VDD   POWER
T10   DDRM_VDD   POWER
V6   DDRM_VDD   POWER
W6   DDRM_VDD   POWER
Y6   DDRM_VDD   POWER
A4   DDRM_VDD   POWER
B6   DDRM_VDD   POWER
J4   DDRM_VDD   POWER
K5   DDRM_VDD   POWER
R4   DDRM_VDD   POWER
R5   DDRM_VDD   POWER
N3   DDRM_VDD   POWER
U4   DDRM_VDD   POWER
Y4   DDRM_VDD   POWER
AA5   DDRM_VDD   POWER
E3   DDRM_VDD   POWER
F2   DDRM_VDD   POWER
L4   DDRM_VDD   POWER
W2   DDRM_VDD   POWER
AA3   DDRM_VDD   POWER
E1   DDRM_VDD   POWER
G1   DDRM_VDD   POWER
H2   DDRM_VDD   POWER
J2   DDRM_VDD   POWER
K1   DDRM_VDD   POWER
M1   DDRM_VDD   POWER
L2   DDRM_VDD   POWER
P1   DDRM_VDD   POWER
V1   DDRM_VDD   POWER
Y1   DDRM_VDD   POWER
R2   DDRM_VDD   POWER
H24   VDDIOP1   POWER
K18   VDDICPU   POWER
K24   VDDQSPI1   POWER
P20   VDDQSPI0   POWER
B18   VDDSDMMC1   POWER
M24   VDDSDMMC0   POWER
D24   VDDSDMMC2   POWER
J15   VDDANA   POWER
T20   VDDDPHY   POWER
U21   VDDDPHY   POWER
K16   VBAT   POWER
F16   VDDUTMI   POWER
B14   VDDUTMI   POWER
B12   VDDUTMI   POWER
B10   VDDUTMI   POWER
B8   VDDUTMI   POWER
R12   DDR_VREF   POWER
E4   DDR_VREF   POWER
G4   DDRM_ZQ   POWER
F14   VDDIN33   POWER
F12   VDDANA   POWER
D9   ADVREFP   POWER
F10   VDDANA   POWER
F21   VDDCPU   POWER
H20   VDDCPU   POWER
G19   VDDCPU   POWER
J19   VDDCPU   POWER
Y16   VDDIOP0   POWER
Y18   VDDIOP0   POWER
F24   VDDIOP1   POWER
G11   VDDCORE   POWER
L13   VDDCORE   POWER
M12   VDDCORE   POWER
T24   VDDCORE   POWER
P21   VDDCORE   POWER
K20   VDDCORE   POWER
N19   VDDCORE   POWER
V19   VDDCORE   POWER
N17   VDDCORE   POWER
J17   VDDCORE   POWER
K17   VDDCORE   POWER
T16   VDDCORE   POWER
T14   VDDCORE   POWER
H12   VDDCORE   POWER
K14   VDDIODDR   POWER
M14   VDDIODDR   POWER
N13   VDDIODDR   POWER
K12   VDDIODDR   POWER
P12   VDDIODDR   POWER
L10   VDDIODDR   POWER
L11   VDDIODDR   POWER
M10   VDDIODDR   POWER
N11   VDDIODDR   POWER
P10   VDDIODDR   POWER
L9   VDDIODDR   POWER
M9   VDDIODDR   POWER
P14   VDDIODDR   POWER
M16   VDDIODDR   POWER
N15   VDDIODDR   POWER
L15   VDDIODDR   POWER
R13   VDDIODDR   POWER
M11   GND   GND
N12   GND   GND
A25   GND   GND
AA25   GND   GND
B24   GND   GND
C23   GND   GND
P24   GND   GND
V24   GND   GND
W23   GND   GND
Y24   GND   GND
D22   GND   GND
D20   GND   GND
K21   GND   GND
M21   GND   GND
T21   GND   GND
R19   GND   GND
E18   GND   GND
L17   GND   GND
L18   GND   GND
M17   GND   GND
M18   GND   GND
N18   GND   GND
P18   GND   GND
J16   GND   GND
L16   GND   GND
K15   GND   GND
L14   GND   GND
M15   GND   GND
N14   GND   GND
U14   GND   GND
K13   GND   GND
M13   GND   GND
P13   GND   GND
L12   GND   GND
T12   GND   GND
U12   GND   GND
J10   GND   GND
K10   GND   GND
K11   GND   GND
N10   GND   GND
P11   GND   GND
R10   GND   GND
R11   GND   GND
T11   GND   GND
U10   GND   GND
W11   GND   GND
Y10   GND   GND
F9   GND   GND
G9   GND   GND
J9   GND   GND
N9   GND   GND
T9   GND   GND
V9   GND   GND
G7   GND   GND
H8   GND   GND
J7   GND   GND
K8   GND   GND
L7   GND   GND
L8   GND   GND
M8   GND   GND
N7   GND   GND
P8   GND   GND
R7   GND   GND
U8   GND   GND
V7   GND   GND
Y7   GND   GND
M6   GND   GND
R6   GND   GND
AA6   GND   GND
AA8   GND   GND
D4   GND   GND
E5   GND   GND
G5   GND   GND
H5   GND   GND
J5   GND   GND
L5   GND   GND
M5   GND   GND
N4   GND   GND
P5   GND   GND
T5   GND   GND
V4   GND   GND
W5   GND   GND
Y5   GND   GND
AA4   GND   GND
C3   GND   GND
G3   GND   GND
J3   GND   GND
L3   GND   GND
R3   GND   GND
U3   GND   GND
W3   GND   GND
A1   GND   GND
B2   GND   GND
E2   GND   GND
F1   GND   GND
G2   GND   GND
H1   GND   GND
J1   GND   GND
K2   GND   GND
L1   GND   GND
M2   GND   GND
N1   GND   GND
N2   GND   GND
P2   GND   GND
R1   GND   GND
T2   GND   GND
U1   GND   GND
V2   GND   GND
W1   GND   GND
Y2   GND   GND
AA1   GND   GND
E21   GND   GND
H21   GND   GND
U16   GND   GND
U18   GND   GND
F20   GND   GND
B16   GND   GND
Y12   GND   GND
V22   GNDDPHY   GND
V20   GNDDPHY   GND
H10   GNDANA   GND
H16   GNDIN33   GND
E14   GNDUTMI   GND
H18   GNDUTMI   GND
E12   GNDUTMI   GND
E10   GNDUTMI   GND
E8   GNDUTMI   GND
E16   GNDANA   GND
H14   GNDANA   GND
N16   GNDBAT   GND
AA23   MIPI_REXT   NC
AA20   MIPI_DP1   NC
Y20   MIPI_DN1   NC
Y21   MIPI_CLKN   NC
AA21   MIPI_CLKP   NC
AA22   MIPI_DP0   NC
Y22   MIPI_DN0   NC
C2   XIN   NC
C1   XOUT   NC
J12   DDR_ZQ   NC
R15   SHDN   NC
P15   LPM   NC
U11   TST   NC
V13   PIOBU0   NC
T15   PIOBU1   NC
V11   PIOBU2   NC
U13   PIOBU3   NC
AA9   XOUT32   NC
Y9   XIN32   NC
T13   JTAGSEL   NC
Y11   WKUP0   NC
A15   HHSC_DP   NC
B15   HHSC_DM   NC
A14   HHSC_RTUNE   NC
D17   HHSB_CC2   NC
C15   HHSB_CC1   NC
A13   HHSB_DP   NC
B13   HHSB_DM   NC
A12   HHSB_RTUNE   NC
D15   HHSA_CC2   NC
C13   HHSA_CC1   NC
A11   HHSA_DP   NC
B11   HHSA_DM   NC
A10   HHSA_RTUNE   NC
B20   SDMMC2_CAL   NC
F18   SDMMC1_CAL   NC
M20   SDMMC0_CAL   NC
R17   QSPI0_CAL   NC
B9   NRST_OUT   NC
G13   NRST   NC
|**********************DIFF PIN************************************************
[Diff pin]  inv_pin   vdiff   tdelay_typ  tdelay_min  tdelay_max
|QSPIO_SCK   QSPI0_SPCKN
W25   W24   NA   NA   NA   NA
|END COMPONENT SAMA7D65D4G_4UB ************************************************
|   Component SAMA7D54D1G_2G_4G_XHB
[Component]   SAMA7D54D1G_2G_4G_XHB
[Manufacturer]  Microchip Technology Inc.
[Package]
| variable   typ   min   max
R_pkg   333.2847m   67.9925m   787.1609m
L_pkg   3.1413nH   1.4223nH   4.7698nH
C_pkg   0.9922pF   0.4592pF   1.9189pF
[Pin]   signal_name   model_name   R_pin   L_pin   C_pin
F7   AUDIOCLK   GPIO   476.0154m   3.4284nH   1.4499pF
T25   PA0   HSIO   136.4835m   2.3579nH   0.656pF
U31   PA1   HSIO   191.5836m   2.9658nH   0.658pF
R26   PA10   HSIO   121.16m   2.2826nH   0.5972pF
R31   PA11   HSIO   213.0021m   2.9291nH   0.7221pF
AK20   PA12   GPIO   364.3978m   2.7837nH   1.1359pF
L20   PA13   GPIO   356.9181m   3.2156nH   1.0326pF
AL21   PA14   GPIO   334.5905m   3.1858nH   0.9928pF
G20   PA15   GPIO   228.5564m   2.5398nH   0.9427pF
L22   PA16   GPIO   357.7348m   3.2688nH   1.0189pF
K21   PA17   GPIO   284.2947m   2.6107nH   1.0991pF
L24   PA18   GPIO   431.9429m   3.1312nH   1.0695pF
K22   PA19   GPIO   292.5724m   2.9535nH   1.1931pF
V25   PA2   GPIO   133.1812m   2.4953nH   0.6566pF
K24   PA20   GPIO   365.1467m   3.0593nH   0.9932pF
G21   PA21   GPIO   216.1007m   2.3595nH   0.8884pF
AL25   PA22   GPIO   420.119m   3.3491nH   1.0858pF
AF21   PA23   GPIO   217.1362m   2.7655nH   0.9947pF
K25   PA24   GPIO   368.4529m   3.1873nH   1.0289pF
G22   PA25   GPIO   207.6691m   2.6764nH   0.9084pF
K26   PA26   GPIO   388.0206m   3.2673nH   1.0664pF
AL26   PA27   GPIO   409.6783m   3.4174nH   1.0921pF
AF22   PA28   GPIO   152.5152m   2.2133nH   0.7509pF
AL28   PA29   GPIO   470.2389m   3.377nH   1.1876pF
V26   PA3   HSIO   117.314m   2.4201nH   0.6198pF
G23   PA30   GPIO   222.5583m   2.5191nH   0.9747pF
L29   PA31   GPIO   502.2m   3.4935nH   1.2166pF
U25   PA4   HSIO   129.7829m   2.5621nH   0.6604pF
U30   PA5   HSIO   137.3242m   2.6499nH   0.5634pF
U26   PA6   HSIO   113.4813m   2.3721nH   0.6289pF
R25   PA7   HSIO   153.2835m   2.2875nH   0.6856pF
R30   PA8   HSIO   150.1077m   2.7205nH   0.6881pF
P31   PA9   HSIO   226.9701m   3.0816nH   0.7874pF
AF23   PB0   GPIO   160.3277m   2.3587nH   0.7765pF
AK28   PB1   GPIO   426.7739m   3.3243nH   1.1508pF
AB28   PB10   HSIO   144.3787m   2.5163nH   0.5848pF
Y30   PB11   HSIO   100.9379m   1.9535nH   0.4809pF
AA28   PB12   HSIO   95.0781m   1.9096nH   0.556pF
AD30   PB13   HSIO   242.6458m   2.5848nH   0.7234pF
AA30   PB14   HSIO_PB14_PB15  130.8114m   2.0777nH   0.508pF
AA31   PB15   HSIO_PB14_PB15  143.4571m   2.2362nH   0.5326pF
W28   PB16   HSIO   88.8072m   1.8961nH   0.4675pF
W31   PB17   HSIO   144.1591m   2.3682nH   0.5031pF
W30   PB18   HSIO   134.6545m   2.3157nH   0.4815pF
W26   PB19   HSIO   120.3771m   2.3543nH   0.6185pF
G24   PB2   GPIO   217.9393m   2.7554nH   0.8257pF
AB30   PB20   HSIO   152.7825m   2.5652nH   0.6884pF
V30   PB21   GPIO   145.9953m   2.5631nH   0.5467pF
P28   PB22   GPIO   90.7414m   1.9163nH   0.5549pF
M31   PB23   GPIO   216.8201m   3.058nH   0.7462pF
P30   PB24   GPIO   156.7352m   2.7348nH   0.6637pF
P25   PB25   GPIO   91.9116m   1.761nH   0.5541pF
N31   PB26   GPIO   243.8259m   3.1341nH   0.8131pF
P26   PB27   GPIO   124.4587m   2.344nH   0.6148pF
F21   PB28   GPIO   320.5836m   2.7554nH   0.8744pF
A22   PB29   HSIO   449.9956m   3.5942nH   1.0433pF
AL30   PB3   GPIO   508.1315m   3.5378nH   1.2322pF
B21   PB30   HSIO   458.4565m   3.1389nH   1.0004pF
B22   PB31   HSIO   380.5966m   3.5154nH   0.9784pF
AF24   PB4   GPIO   152.5154m   2.1421nH   0.7537pF
AK30   PB5   GPIO   456.5828m   3.2329nH   1.227pF
G25   PB6   GPIO   185.3672m   2.3248nH   0.6591pF
K29   PB7   GPIO   523.0103m   2.8396nH   1.148pF
AF25   PB8   GPIO   156.3317m   2.0917nH   0.7216pF
AD31   PB9   HSIO   263.0408m   2.7207nH   0.6412pF
A21   PC0   HSIO   469.6232m   3.4529nH   1.0407pF
E22   PC1   HSIO   314.2226m   2.7565nH   0.8319pF
G2   PC10   GPIO   588.483m   4.2266nH   1.8538pF
K18   PC11   GPIO   118.764m   1.8204nH   0.768pF
E1   PC12   GPIO   669.5618m   4.5836nH   1.5878pF
K20   PC13   GPIO   98.5436m   2.0762nH   0.5596pF
E12   PC14   GPIO   455.8862m   3.4748nH   1.1473pF
F11   PC15   GPIO   393.5173m   3.4373nH   1.1853pF
F12   PC16   GPIO   401.6424m   3.5433nH   1.0634pF
E10   PC17   GPIO   428.2093m   3.7087nH   1.2536pF
B8   PC18   GPIO   681.7293m   4.1779nH   1.4835pF
F10   PC19   GPIO   430.7607m   3.2689nH   1.1834pF
F22   PC2   HSIO   273.4365m   2.6721nH   0.7645pF
A8   PC20   GPIO   669.5396m   4.3678nH   1.5276pF
E11   PC21   GPIO   432.272m   3.6436nH   1.2072pF
B7   PC22   GPIO   633.1794m   4.2539nH   1.5194pF
A7   PC23   GPIO   671.3745m   4.4708nH   1.5187pF
F9   PC24   GPIO   445.4638m   3.2243nH   1.1993pF
B2   PC25   GPIO   736.4608m   4.4348nH   1.6358pF
E2   PC26   GPIO   554.825m   4.3537nH   1.8464pF
D2   PC27   GPIO   626.9613m   4.6113nH   1.5501pF
B4   PC28   GPIO   600.1067m   4.128nH   1.5277pF
A4   PC29   GPIO   697.4067m   4.5111nH   1.5468pF
G1   PC3   GPIO   744.0372m   4.0705nH   1.5878pF
B6   PC30   GPIO   684.2685m   4.2025nH   1.55pF
A6   PC31   GPIO   699.6984m   4.1997nH   1.646pF
B3   PC4   GPIO   716.5379m   4.3021nH   1.9189pF
A3   PC5   GPIO   679.2695m   4.7521nH   1.5414pF
L17   PC6   GPIO   71.6197m   1.4223nH   0.5265pF
F2   PC7   GPIO   512.2776m   4.3413nH   1.8291pF
F1   PC8   GPIO   694.9069m   4.3393nH   1.5814pF
D1   PC9   GPIO   661.9637m   4.7698nH   1.6193pF
E7   PD0   GPIO   529.3089m   4.4273nH   1.3169pF
E8   PD1   GPIO   489.8918m   3.9914nH   1.2417pF
N25   PD10   GPIO   144.1904m   2.6437nH   0.7017pF
L31   PD11   GPIO   204.2103m   3.3354nH   0.7969pF
N28   PD12   GPIO   85.2854m   1.9758nH   0.5207pF
N26   PD13   GPIO   67.9925m   1.672nH   0.4592pF
H31   PD14   GPIO   265.3159m   3.4197nH   0.8955pF
M28   PD15   GPIO   93.4685m   2.0459nH   0.5952pF
K31   PD16   GPIO   206.8577m   3.2878nH   0.8011pF
M25   PD17   GPIO   87.8551m   2.0461nH   0.5835pF
F31   PD18   GPIO   313.5129m   3.9757nH   1.1221pF
M30   PD19   GPIO   103.4804m   2.1663nH   0.5961pF
B24   PD2   GPIO   436.5191m   3.3132nH   1.0054pF
G31   PD20   GPIO   287.1886m   3.6229nH   0.9878pF
L28   PD21   GPIO   107.0555m   2.1188nH   0.6388pF
D31   PD22   GPIO   387.9933m   4.4401nH   1.1686pF
L30   PD23   GPIO   111.4156m   2.4009nH   0.6387pF
C31   PD24   GPIO   398.9165m   4.5952nH   1.1981pF
K30   PD25   GPIO   120.8936m   2.449nH   0.6741pF
G30   PD26   GPIO   226.1354m   3.0748nH   0.8548pF
E31   PD27   GPIO   331.4619m   3.9959nH   1.0151pF
F30   PD28   GPIO   261.7554m   3.1445nH   0.926pF
B30   PD29   GPIO   409.7117m   4.3832nH   1.2433pF
A24   PD3   HSIO   510.5519m   3.6152nH   1.0629pF
E30   PD30   GPIO   306.3134m   3.1198nH   0.9655pF
A29   PD31   GPIO   449.9033m   4.2932nH   1.3149pF
F24   PD4   HSIO   259.816m   2.9087nH   0.7797pF
E25   PD5   HSIO   323.7264m   2.9987nH   0.8628pF
E24   PD6   HSIO   338.2886m   3.0485nH   0.8728pF
E23   PD7   HSIO   313.6981m   2.949nH   0.9142pF
F23   PD8   HSIO   286.1635m   2.8193nH   0.8428pF
N30   PD9   GPIO   148.1186m   2.6241nH   0.689pF
A28   PE0   GPIO   787.1609m   4.4817nH   1.5232pF
B25   PE1   GPIO   515.2709m   3.3037nH   1.3081pF
A27   PE2   GPIO   464.8318m   4.3693nH   1.3071pF
A25   PE3   GPIO   531.4542m   4.6817nH   1.2788pF
B27   PE4   GPIO   427.8283m   3.2955nH   1.2104pF
A26   PE5   GPIO   488.0075m   4.563nH   1.3026pF
B26   PE6   GPIO   431.812m   3.4888nH   1.2773pF
B28   PE7   GPIO   431.3279m   3.1255nH   1.1254pF
K14   ADVREFP   POWER
Y22   VDDIN33   POWER
AA21   VDDIOP0   POWER
AF19   VDDIOP0   POWER
J30   VDDIOP1   POWER
R28   VDDIOP1   POWER
K19   VDDANA   POWER
N15   VDDANA   POWER
N17   VDDANA   POWER
B16   VDDCORE   POWER
K28   VDDCORE   POWER
L15   VDDCORE   POWER
L21   VDDCORE   POWER
R15   VDDCORE   POWER
T30   VDDCORE   POWER
U20   VDDCORE   POWER
U22   VDDCORE   POWER
U23   VDDCORE   POWER
W15   VDDCORE   POWER
Y23   VDDCORE   POWER
AB20   VDDCORE   POWER
AF26   VDDCORE   POWER
AK16   VDDCORE   POWER
F26   VDDCPU   POWER
M23   VDDCPU   POWER
N23   VDDCPU   POWER
P23   VDDCPU   POWER
R23   VDDCPU   POWER
L2   DDR_VREF   POWER
T14   DDR_ZQ   POWER
Y25   VDDDPHY   POWER
AA25   VDDDPHY   POWER
M22   VBAT   POWER
H30   VDDSDMMC2   POWER
Y28   VDDSDMMC0   POWER
F25   VDDSDMMC1   POWER
AC30   VDDQSPI0   POWER
U28   VDDQSPI1   POWER
AA19   VDDIODDR   POWER
AB19   VDDIODDR   POWER
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| Models and submodels in the file (32): HSIO_PB15_IN_OUT_50_1v8 (I/O), HSIO_PB15_IN_OUT_66_1v8 (I/O), HSIO_PB15_IN_OUT_33_1v8 (I/O), HSIO_PB15_IN_OUT_100_1v8 (I/O), HSIO_PB14_IN_OUT_50_1v8 (I/O), HSIO_PB14_IN_OUT_66_1v8 (I/O), HSIO_PB14_IN_OUT_33_1v8 (I/O), HSIO_PB14_IN_OUT_100_1v8 (I/O), HSIO_IN_OUT_50_1v8 (I/O), HSIO_IN_OUT_66_1v8 (I/O), HSIO_IN_OUT_33_1v8 (I/O), HSIO_IN_OUT_100_1v8 (I/O), GPIO_DRV0_SR0_1v8 (I/O), GPIO_DRV0_SR1_1v8 (I/O), GPIO_DRV1_SR0_1v8 (I/O), GPIO_DRV1_SR1_1v8 (I/O), HSIO_PB15_IN_OUT_42_3v3 (I/O), HSIO_PB15_IN_OUT_56_3v3 (I/O), HSIO_PB15_IN_OUT_28_3v3 (I/O), HSIO_PB15_IN_OUT_84_3v3 (I/O), HSIO_PB14_IN_OUT_42_3v3 (I/O), HSIO_PB14_IN_OUT_56_3v3 (I/O), HSIO_PB14_IN_OUT_28_3v3 (I/O), HSIO_PB14_IN_OUT_84_3v3 (I/O), HSIO_IN_OUT_42_3v3 (I/O), HSIO_IN_OUT_56_3v3 (I/O), HSIO_IN_OUT_28_3v3 (I/O), HSIO_IN_OUT_84_3v3 (I/O), GPIO_DRV0_SR0_3v3 (I/O), GPIO_DRV0_SR1_3v3 (I/O), GPIO_DRV1_SR0_3v3 (I/O), GPIO_DRV1_SR1_3v3 (I/O)
